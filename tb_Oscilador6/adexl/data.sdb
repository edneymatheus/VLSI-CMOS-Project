ADE simulation setup
Run mode: Single Run, Sweeps and Corners
Tests:
  PSI_5723:tb_Oscilador6:1: PSI_5723/tb_Oscilador6/schematic, simulator spectre
Global variables:
  var = 1.32
