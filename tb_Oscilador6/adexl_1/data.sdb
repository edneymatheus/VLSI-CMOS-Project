ADE simulation setup
Run mode: Single Run, Sweeps and Corners
Tests:
  PSI_5723:tb_Oscilador6:1: PSI_5723/tb_Oscilador6/schematic, simulator spectre
    Outputs: tpdf; tpdr; tsubida; tdescida
Global variables:
  var = 1.32
Corners (nominal off):
  model folders: /local/tools/pdk/tsmc013/2014j/TSMC/1p7m_4X1Z1U_CURDL/models/spectre
  FastFast (off): temperature=0; var=1.32; cor_std_mos.scs[ff]
  SlowSlow: temperature=125; var=1.08; cor_std_mos.scs[ss]
  TypTyp: temperature=125; var=1.08; cor_std_mos.scs[tt]
