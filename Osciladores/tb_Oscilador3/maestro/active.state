ADE simulation setup
Test PSI_5723:tb_Oscilador3:1: PSI_5723/tb_Oscilador3/schematic, simulator spectre
  Models: /local/tools/pdk/tsmc013/2014j/TSMC/1p7m_4X1Z1U_CURDL/tsmc13rf/../models/spectre/tsmc13rf.scs
  Variables: vdc = 1.2
  Temperature: 27
  Initial conditions: /Vin = 0
  Analysis tran: stop=8n errpreset=conservative
  Output P = getData(":pwr" ?result "tran")
  Output Pmed = average(getData(":pwr" ?result "tran"))
  Output f = frequency(VT("/Vout"))
  Signals: /Vin as Vin, /Vout as Vout, /I0/Vdd (terminal) as I
