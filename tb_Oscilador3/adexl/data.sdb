ADE simulation setup
Run mode: Single Run, Sweeps and Corners
Tests:
  PSI_5723:tb_Oscilador3:1: PSI_5723/tb_Oscilador3/schematic, simulator spectre
    Outputs: I
Global variables:
  vdc = 1.2
Corners (nominal off):
  every corner: /local/tools/pdk/tsmc013/2014j/TSMC/1p7m_4X1Z1U_CURDL/models/spectre/cor_std_mos.scs[tt]
  C0: temperature=27; vdc=0.96
  C1: temperature=27; vdc=1.08
  C2: temperature=27; vdc=1.2
  C3: temperature=27; vdc=1.32
  C4: temperature=27; vdc=1.44
